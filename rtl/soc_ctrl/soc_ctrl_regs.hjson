# Copyright 2024 ETH Zurich and University of Bologna
# Solderpad Hardware License, Version 0.51, see LICENSE for details.
# SPDX-License-Identifier: SHL-0.51

{
  name: "soc_ctrl",
  clock_primary: "clk_i",
  reset_primary: "rst_ni",
  bus_interfaces: [
    { protocol: "reg_iface",
      direction: "device"
    }
  ],

  regwidth: "32",
  registers: [
    { name: "bootaddr",
      desc: "Core Boot Address",
      swaccess: "rw",
      hwaccess: "hro",
      fields: [
        { bits: "31:0",
          name: "bootaddr",
          desc: "Boot Address",
          resval: 0x0300_D000
        }
      ]

    },
    { name: "fetchen",
      desc: "Core Fetch Enable",
      swaccess: "rw",
      hwaccess: "hrw",
      fields: [
        { bits: "0",
          name: "fetchen",
          desc: "Fetch Enable",
          resval: 0
        }
      ]
    },
    { name: "corestatus",
      desc: "Core Return Status (return value, EOC)",
      swaccess: "rw",
      hwaccess: "hro",
      fields: [
        { bits: "31:0",
          name: "core_status",
          desc: "Core Return Status (EOC(bit[31]) and status(bit[30:0]))",
          resval: 0
        }
      ]
    },
    { name: "bootmode",
      desc: "Core Boot Mode",
      swaccess: "rw",
      hwaccess: "hrw",
      fields: [
        { bits: "0",
          name: "bootmode",
          desc: "Boot Mode",
          resval: 0x0
        }
      ]
    },
    { name: "sram_dly",
      desc: "SRAM A_DLY value",
      swaccess: "rw",
      hwaccess: "hro",
      fields: [
        { bits: "0",
          name: "sram_dly",
          desc: "Controls the A_DLY pin of the SRAMs (configured internal timings)",
          resval: 0x1
        }
      ]
    },
    { name: "restart_counter",
      desc: "Bootrom restarts counter",
      swaccess: "rw",
      hwaccess: "hrw",
      fields: [
        { bits: "31:0",
          name: "restart_counter",
          desc: "Restart Counter",
          resval: 0x0000_0000
        }
      ]

    },
    { name: "bootaddr_after",
      desc: "Core Boot Address After Bootrom",
      swaccess: "rw",
      hwaccess: "hro",
      fields: [
        { bits: "31:0",
          name: "bootaddr_after",
          desc: "Boot Address After Bootrom",
          resval: 0x1000_0000
        }
      ]

    },
    { name: "bootaddr_after_sd",
      desc: "Core Boot Address After Bootrom if SD Card is attached",
      swaccess: "rw",
      hwaccess: "hro",
      fields: [
        { bits: "31:0",
          name: "bootaddr_after_sd",
          desc: "Boot Address After Bootrom if SD Card is attached",
          resval: 0x1000_0800
        }
      ]

    },

  ],
}
